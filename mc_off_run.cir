.control
setseed 12345
let n = 750
let k = 0
while k < n
  reset
  op
  print v(vo1) v(vo2) >> /foss/designs/gmc-filter/results_off_pt.txt
  let k = k + 1
end
quit
.endc
