.control
op
noise v(vo2) vinp dec 20 1k 10Meg
setplot noise1
wrdata /foss/designs/gmc-filter/curves_noise_pt.txt onoise_spectrum inoise_spectrum
setplot noise2
print onoise_total inoise_total
quit
.endc
