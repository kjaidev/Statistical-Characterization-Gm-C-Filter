.control
op
print v(vo2)
let pw = -v1#branch[0]*1.8
print pw
ac dec 20 100k 10Meg
meas ac f3 when vdb(vo2)=-3 fall=1
meas ac f90 when vp(vo2)=-1.5708 fall=1
meas ac pk max vdb(vo2)
meas ac g find vdb(vo2) at=100k
print f3 f90 pk g
quit
.endc
