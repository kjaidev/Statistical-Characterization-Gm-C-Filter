beta multiplier probe
V1 VDD 0 DC 1.98
Vsns nr 0 DC 0
XMP1 n1 pg VDD VDD sky130_fd_pr__pfet_01v8 w=8 l=2
XMP2 n2 pg VDD VDD sky130_fd_pr__pfet_01v8 w=8 l=2
XM1 n1 n1 0 0 sky130_fd_pr__nfet_01v8 w=2 l=2
XM2 n2 n1 ns 0 sky130_fd_pr__nfet_01v8 w=8 l=2
XR1 ns nr 0 sky130_fd_pr__res_high_po_1p41 w=1.41 l=65
Rst VDD n1 5Meg
Rpg n2 pg 1
.nodeset v(n1)=0.8 v(n2)=0.9 v(pg)=0.9
.lib /foss/pdks/sky130A/libs.tech/combined/sky130.lib.spice ff
.dc temp -40 125 5
.control
run
let ibr = -i(Vsns)
wrdata pp_out.txt ibr v(n1) v(n2)
quit
.endc
.end
