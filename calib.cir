.control
op
let pw = -v1#branch[0]*1.8
print pw
ac dec 20 100k 10Meg
meas ac f3 when vdb(vo2)=-3 fall=1
meas ac f90 when vp(vo2)=-1.5708 fall=1
meas ac pk max vdb(vo2)
print f3 f90 pk
quit
.endc
