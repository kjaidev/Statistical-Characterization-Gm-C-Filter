.control
ac dec 40 100k 10Meg
let mg=db(v(vo2))
let pg=180/pi*cph(v(vo2))
wrdata /foss/designs/gmc-filter/curves_ac_nom.txt mg pg
.endc
