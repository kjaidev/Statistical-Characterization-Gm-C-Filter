** gmc_pt: Gm-C biquad, current-mode bias with PTAT-like reference  I = iref*(T/300.15K)^alpha
.temp -20
Vinp vin 0 0.9 ac 1
V1 VDD 0 1.8
Vinn vcm 0 0.9
* reference leg 1 (drawn from VDD, counted in power) -> x1, x2 tails
BIref VDD vbn I = {iref}*pow((temper+273.15)/300.15,{alpha})
XMr vbn vbn 0 0 sky130_fd_pr__nfet_01v8 L=1 W=6 nf=1 ad=1.74 as=1.74 pd=12.58 ps=12.58 nrd=0.0483333333333333 nrs=0.0483333333333333 sa=0 sb=0 sd=0 mult=1
* reference leg 2 = rt * Iref (stands in for a ratioed copy; fed from an aux supply so it is not double-counted)
Vaux vaux 0 1.8
BIref3 vaux vbn3 I = {iref*rt}*pow((temper+273.15)/300.15,{alpha})
XMr3 vbn3 vbn3 0 0 sky130_fd_pr__nfet_01v8 L=1 W=6 nf=1 ad=1.74 as=1.74 pd=12.58 ps=12.58 nrd=0.0483333333333333 nrs=0.0483333333333333 sa=0 sb=0 sd=0 mult=1
C1 vo1 0 10p
C2 vo2 0 10p
x1 vo1 vin vo2 vbn ota_core
x2 vo2 vo1 vcm vbn ota_core
x3 vo1 vcm vo1 vbn3 ota_core
.param iref=12u rt=1.48 alpha=0.6
.lib /foss/pdks/sky130A/libs.tech/combined/sky130.lib.spice sf_mm
.include /foss/designs/gmc-filter/mcpt_pt_sf_1.8_-20.cir

.subckt ota_core OUT1 IN1+ IN1- Vbias_tail
XM1 net2 IN1+ net1 0 sky130_fd_pr__nfet_01v8 L=0.5 W=4 nf=1 ad=1.16 as=1.16 pd=8.58 ps=8.58 nrd=0.0725 nrs=0.0725 sa=0 sb=0 sd=0
+ mult=1
XM2 OUT1 IN1- net1 0 sky130_fd_pr__nfet_01v8 L=0.5 W=4 nf=1 ad=1.16 as=1.16 pd=8.58 ps=8.58 nrd=0.0725 nrs=0.0725 sa=0 sb=0 sd=0
+ mult=1
XM3 net2 net2 VDD VDD sky130_fd_pr__pfet_01v8 L=0.5 W=8 nf=1 ad=2.32 as=2.32 pd=16.58 ps=16.58 nrd=0.03625 nrs=0.03625 sa=0 sb=0
+ sd=0 mult=1
XM4 OUT1 net2 VDD VDD sky130_fd_pr__pfet_01v8 L=0.5 W=8 nf=1 ad=2.32 as=2.32 pd=16.58 ps=16.58 nrd=0.03625 nrs=0.03625 sa=0 sb=0
+ sd=0 mult=1
XM5 net1 Vbias_tail 0 0 sky130_fd_pr__nfet_01v8 L=1 W=6 nf=1 ad=1.74 as=1.74 pd=12.58 ps=12.58 nrd=0.0483333333333333
+ nrs=0.0483333333333333 sa=0 sb=0 sd=0 mult=1
.ends

.GLOBAL VDD
.end
