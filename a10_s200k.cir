.control
setseed 12345
set appendwrite
repeat 200
 reset
 tran 3.90625e-08 5e-05 0 3.90625e-08
 linearize v(vo2)
 wrdata a10_s200k.txt v(vo2)
end
quit
.endc
